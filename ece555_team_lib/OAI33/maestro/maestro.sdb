ADE simulation setup
Run mode: Single Run, Sweeps and Corners
Tests:
  ECE555_OAI33_1: ece555_team_lib/OAI33/schematic, simulator hspiceD
