ADE simulation setup
Test ECE555_OAI33_1: ece555_team_lib/OAI33/schematic, simulator hspiceD
Run mode: Single Run, Sweeps and Corners
